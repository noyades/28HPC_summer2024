ADE simulation setup
Test dev28_behdad_tb_dev22_scpa_digital_PA_1: dev28_behdad/tb_dev22_scpa_digital_PA/schematic_signle_slice, simulator spectre
  Models: /software/RFIC/PDK/tsmc/28nm/v1.8_2p3a/tsmcN28/../models/spectre/toplevel.scs[top_tt]
  Variables: _EXPR_1 = 3.90625e-12; code_I = 0; t_start = 0; R1 = 8*19.12; L = 444.4p; vdd = 0.9; N = 8; frq = 12.8G; code_Q = 128; res = 2**N - 1; T = 1/frq; t_stop = 80*T
  Temperature: 27
  Analysis tran: start=VAR("t_start") stop=VAR("t_stop") errpreset=conservative strobeperiod=1/(20*VAR("frq")) skipdc=yes
  Output v /VOP; tran (V) = vtime('tran "/VOP") (unticked)
  Output v /VON; tran (V) = vtime('tran "/VON") (unticked)
  Output v /QB; tran (V) = vtime('tran "/QB") (unticked)
  Output v /Q; tran (V) = vtime('tran "/Q") (unticked)
  Output v /I; tran (V) = vtime('tran "/I") (unticked)
  Output v /IB; tran (V) = vtime('tran "/IB") (unticked)
  Output v /CK_ph2; tran (V) = vtime('tran "/CK_ph2") (unticked)
  Output v /CK_ph3; tran (V) = vtime('tran "/CK_ph3") (unticked)
  Output v /CK_ph4; tran (V) = vtime('tran "/CK_ph4") (unticked)
  Output v /CK_ph5; tran (V) = vtime('tran "/CK_ph5") (unticked)
  Output v /CK_ph6; tran (V) = vtime('tran "/CK_ph6") (unticked)
  Output v /CK_ph7; tran (V) = vtime('tran "/CK_ph7") (unticked)
  Output v /CK_ph1; tran (V) = vtime('tran "/CK_ph1") (unticked)
  Output v /CK_ph8; tran (V) = vtime('tran "/CK_ph8") (unticked)
  Output v /net15; tran (V) = vtime('tran "/net15") (unticked)
  Output v /net16; tran (V) = vtime('tran "/net16") (unticked)
  Output v /I0/B0/I0/I1<31>/net13; tran (V) = vtime('tran "/I0/B0/I0/I1<31>/net13") (unticked)
  Output v /I0/B0/I0/I1<31>/net16; tran (V) = vtime('tran "/I0/B0/I0/I1<31>/net16") (unticked)
  Output Vo_diff = (vtime('tran "/VON") - vtime('tran "/VOP")) (unticked)
  Output tstart = (VAR("t_stop") - (3 / VAR("frq")))
  Output tend = VAR("t_stop")
  Output (vtime('tran "/VOP") - vtime('tran "/VON")) (unticked)
  Output dft((vtime('tran "/VOP") - vtime('tran "/VON")) (122 * VAR("T")) (142 * VAR("T")) 63 "BlackmanHarris" 1 "default" 1) (unticked)
  Output dft((vtime('tran "/VOP") - vtime('tran "/VON")) tstart tend 63 "BlackmanHarris" 1 "default" 1) (unticked)
  Output dft_amplitude = dB20(abs(dft((vtime('tran "/VOP") - vtime('tran "/VON")) tstart tend 63 "BlackmanHarris" 1 "default" 1))) (unticked)
  Output dft_angle = phaseDeg(dft((vtime('tran "/VOP") - vtime('tran "/VON")) (122 * VAR("T")) (142 * VAR("T")) 64 "Blackman" 1 1 1.0)) (unticked)
  Output dft_angle_unwrapped = phaseDegUnwrapped(dft((vtime('tran "/VOP") - vtime('tran "/VON")) tstart tend 64 "BlackmanHarris" 1 "default" 1)) (unticked)
  Output v /net2; tran (V) = vtime('tran "/net2") (unticked)
  Output v /net3; tran (V) = vtime('tran "/net3") (unticked)
  Output v /net11; tran (V) = vtime('tran "/net11") (unticked)
  Output v /net14; tran (V) = vtime('tran "/net14") (unticked)
  Output v /net10; tran (V) = vtime('tran "/net10") (unticked)
  Output v /net5; tran (V) = vtime('tran "/net5") (unticked)
  Output v /net6; tran (V) = vtime('tran "/net6") (unticked)
  Output dft((vtime('tran "/VOP") - vtime('tran "/VON")) (283 * VAR("T")) (291 * VAR("T")) 32 "BlackmanHarris" 1 "default" 1) (unticked)
  Output Vout_diff = (VT("/VON") - VT("/VOP"))
  Output 20_cycle_clip = clip((VT("/VON") - VT("/VOP")) (55 * VAR("T")) (75 * VAR("T")))
  Output Vswing = abs((ymax(clip((VT("/VON") - VT("/VOP")) (55 * VAR("T")) (75 * VAR("T")))) - ymin(clip((VT("/VON") - VT("/VOP")) (55 * VAR("T")) (75 * VAR("T"))))))
  Output Ropt = VAR("R1")
  Output Pout_lin = ((Vswing**2) / (2 * Ropt))
  Output Pout_dbm = dBm(Pout_lin)
  Output pout_dbm2 = (10 * log10((Pout_lin / 0.001)))
  Output LSB = (VAR("vdd") / (2**8))
  Output I = (VAR("code_I") * LSB)
  Output Q = (VAR("code_Q") * LSB)
  Output Amp = sqrt(((I**2) + (Q**2)))
  Output diff = ((Amp - Vsing) / LSB)
  Output dft(Vout_diff 9.087926e-10 6.25e-09 2048 "BlackmanHarris" 0 0 1) (unticked)
  Output abs(dft(Vout_diff 9.087926e-10 6.25e-09 2048 "BlackmanHarris" 1 1 1)) (unticked)
  Output (Vswing / (4 * LSB))
  Output spectrum_Vout_diff = dft(Vout_diff 3.75e-09 6.25e-09 256 "BlackmanHarris" 1 1 1)
  Output magnitude = abs(spectrum_Vout_diff)
  Output ymax(magnitude)
  Signals: /VOP, /VON, /net6
Run mode: Single Run, Sweeps and Corners
Corners (nominal off):
  model folders: /software/RFIC/PDK/tsmc/28nm/v1.8_2p3a/tsmcN28/../models/spectre
  LSB (off): code_I=8:8:32; code_Q=128; toplevel.scs[top_tt]
  ISB (off): code_I=36:4:64; code_Q=255 - code_I; toplevel.scs[top_tt]
  IMSB (off): code_I=68:16:128; code_Q=255 - code_I; toplevel.scs[top_tt]
  MSB (off): code_I=136:32:255; code_Q=255 - code_I; toplevel.scs[top_tt]
  SS_90 (off): temperature=90; toplevel.scs[top_ss]
  TT_90 (off): temperature=90; toplevel.scs[top_tt]
  TT_30 (off): temperature=30; toplevel.scs[top_tt]
  SS_30 (off): toplevel.scs[top_ss]
  C0: temperature=30; code_I=0,32,64,128; code_Q=0,32,64,128; toplevel.scs[top_tt]
  C1: temperature=30; code_I=1,31,63,127; code_Q=1,31,63,127; toplevel.scs[top_tt]
