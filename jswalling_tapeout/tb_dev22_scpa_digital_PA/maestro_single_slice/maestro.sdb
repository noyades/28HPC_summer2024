ADE simulation setup
Run mode: Single Run, Sweeps and Corners
Tests:
  dev28_behdad_tb_dev22_scpa_digital_PA_1: dev28_behdad/tb_dev22_scpa_digital_PA/schematic_signle_slice, simulator spectre
    Variables: t_stop = 80*T; res = 2**N - 1; T = 1/frq; vdd = 0.9; N = 8; frq = 12.8G; L = 444.4p; R1 = 8*19.12; t_start = 0; code_I = 0; code_Q = 128
    Outputs: tstart; tend; dft((vtime('tran "/VOP") - vtime('tran "/VON")) (122 * VAR("T")) (142 * VAR("T")) 511 "Blackman" 1 1 1.0); dft_amplitude; dft_angle_unwrapped; dft_angle; c; dB20(abs(dft((vtime('tran "/VOP") - vtime('tran "/VON")) (122 * VAR("T")) (142 * VAR("T")) 63 "BlackmanHarris" 1 "default" 1))); dft((vtime('tran "/VOP") - vtime('tran "/VON")) tstart tend 63 "BlackmanHarris" 1 "default" 1); dft((vtime('tran "/VOP") - vtime('tran "/VON")) (122 * VAR("T")) (142 * VAR("T")) 63 "BlackmanHarris" 1 "default" 1); dft((vtime('tran "/VOP") - vtime('tran "/VON")) (283 * VAR("T")) (291 * VAR("T")) 127 "BlackmanHarris" 1 "default" 1); dft((vtime('tran "/VOP") - vtime('tran "/VON")) (283 * VAR("T")) (291 * VAR("T")) 31 "BlackmanHarris" 1 "default" 1); dft((vtime('tran "/VOP") - vtime('tran "/VON")) (283 * VAR("T")) (291 * VAR("T")) 32 "BlackmanHarris" 1 "default" 1); Ropt; Pout_lin; pout_dbm2; LSB; I; Q; Amp; diff; 20_cycle_clip; Vswing; dft(Vout_diff 9.087926e-10 6.25e-09 2048 "BlackmanHarris" 0 0 1); (Vswing / (2 * LSB)); (Vswing / (4 * LSB)); magnitude
Corners (nominal off):
  model folders: /software/RFIC/PDK/tsmc/28nm/v1.8_2p3a/tsmcN28/../models/spectre
  LSB (off): code_I=8:8:32; code_Q=128; toplevel.scs[top_tt]
  ISB (off): code_I=36:4:64; code_Q=255 - code_I; toplevel.scs[top_tt]
  IMSB (off): code_I=68:16:128; code_Q=255 - code_I; toplevel.scs[top_tt]
  MSB (off): code_I=136:32:255; code_Q=255 - code_I; toplevel.scs[top_tt]
  SS_90 (off): temperature=90; toplevel.scs[top_ss]
  TT_90 (off): temperature=90; toplevel.scs[top_tt]
  TT_30 (off): temperature=30; toplevel.scs[top_tt]
  SS_30 (off): toplevel.scs[top_ss]
  C0: temperature=30; code_I=0,32,64,128; code_Q=0,32,64,128; toplevel.scs[top_tt]
  C1: temperature=30; code_I=1,31,63,127; code_Q=1,31,63,127; toplevel.scs[top_tt]
