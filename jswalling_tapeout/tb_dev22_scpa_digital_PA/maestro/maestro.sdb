ADE simulation setup
Run mode: Single Run, Sweeps and Corners
Tests:
  dev28_behdad_tb_dev22_scpa_digital_PA_1: dev28_behdad/tb_dev22_scpa_digital_PA/schematic, simulator spectre
    Variables: t_stop = 80*T; res = 2**N - 1; T = 1/frq; vdd = 0.9; N = 8; frq = 12.8G; L = 444.4p; R1 = 44.8; t_start = 0; code_I = 0; code_Q = 255; td = 1n
    Outputs: Vout_diff; 20_cycle_clip; Vswing; Ropt; Pout_lin; Pout_dbm; LSB; I; Q; Amp; diff; tstart; tend
Corners:
  LSB: code_I=0:8:32
  ISB (off): code_I=36:4:64
  IMSB (off): code_I=68:16:128
  MSB (off): code_I=136:32:255
