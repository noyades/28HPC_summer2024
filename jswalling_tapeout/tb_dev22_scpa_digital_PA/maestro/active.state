ADE simulation setup
Test dev28_behdad_tb_dev22_scpa_digital_PA_1: dev28_behdad/tb_dev22_scpa_digital_PA/schematic, simulator spectre
  Models: /projects/eddie_pritchard/RFIC/PDK/tsmc/28nm/v1.8_2p3a/tsmcN28/../models/spectre/toplevel.scs[top_tt]
  Variables: td = 1n; code_Q = 255; code_I = 0; t_start = 0; R1 = 44.8; L = 444.4p; vdd = 0.9; N = 8; frq = 12.8G; res = 2**N - 1; T = 1/frq; t_stop = 80*T
  Temperature: 27
  Analysis tran: start=VAR("t_start") stop=VAR("t_stop") skipdc=yes
  Output Vout_diff = (VT("/VON") - VT("/VOP"))
  Output 20_cycle_clip = clip((VT("/VON") - VT("/VOP")) (55 * VAR("T")) (75 * VAR("T")))
  Output Vswing = abs((ymax(clip((VT("/VON") - VT("/VOP")) (55 * VAR("T")) (75 * VAR("T")))) - ymin(clip((VT("/VON") - VT("/VOP")) (55 * VAR("T")) (75 * VAR("T"))))))
  Output Ropt = (VAR("R1") * 2)
  Output Pout_lin = ((Vswing**2) / (2 * Ropt))
  Output Pout_dbm = dBm(Pout_lin)
  Output LSB = (VAR("vdd") / (2**8))
  Output I = (VAR("code_I") * LSB)
  Output Q = (VAR("code_Q") * LSB)
  Output Amp = sqrt(((I**2) + (Q**2)))
  Output diff = ((Amp - Vsing) / LSB)
  Output tstart = (VAR("t_stop") - (10 / VAR("frq")))
  Output tend = VAR("t_stop")
  Signals: /VOP, /VON
Run mode: Single Run, Sweeps and Corners
Corners:
  LSB: code_I=0:8:32
  ISB (off): code_I=36:4:64
  IMSB (off): code_I=68:16:128
  MSB (off): code_I=136:32:255
