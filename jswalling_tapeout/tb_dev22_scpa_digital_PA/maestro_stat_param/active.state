ADE simulation setup
Test dev28_behdad_tb_dev22_scpa_digital_PA_1: dev28_behdad/tb_dev22_scpa_digital_PA/schematic_stat_param, simulator spectre
  Models: /software/RFIC/PDK/tsmc/28nm/v1.8_2p3a/tsmcN28/../models/spectre/toplevel.scs[top_tt]
  Variables: code_Q = 255; code_I = 0; t_start = 0; R1 = 0.27; L = 47p; vdd = 0.9; N = 8; frq = 1.28G; td = 0; res = 2**N - 1; T = 1/frq; t_stop = 500*T
  Temperature: 27
  Analysis tran: start=VAR("t_start") stop=VAR("t_stop") errpreset=liberal skipdc=yes
  Output v /VOP; tran (V) = vtime('tran "/VOP")
  Output v /VON; tran (V) = vtime('tran "/VON")
  Output v /QB; tran (V) = vtime('tran "/QB")
  Output v /Q; tran (V) = vtime('tran "/Q")
  Output v /I; tran (V) = vtime('tran "/I")
  Output v /IB; tran (V) = vtime('tran "/IB")
  Output v /CK_ph2; tran (V) = vtime('tran "/CK_ph2")
  Output v /CK_ph3; tran (V) = vtime('tran "/CK_ph3")
  Output v /CK_ph4; tran (V) = vtime('tran "/CK_ph4")
  Output v /CK_ph5; tran (V) = vtime('tran "/CK_ph5")
  Output v /CK_ph6; tran (V) = vtime('tran "/CK_ph6")
  Output v /CK_ph7; tran (V) = vtime('tran "/CK_ph7")
  Output v /CK_ph1; tran (V) = vtime('tran "/CK_ph1")
  Output v /CK_ph8; tran (V) = vtime('tran "/CK_ph8")
  Output v /net15; tran (V) = vtime('tran "/net15")
  Output v /net16; tran (V) = vtime('tran "/net16")
  Output v /I0/B0/I0/I1<31>/net13; tran (V) = vtime('tran "/I0/B0/I0/I1<31>/net13")
  Output v /I0/B0/I0/I1<31>/net16; tran (V) = vtime('tran "/I0/B0/I0/I1<31>/net16")
  Output Vo_diff = (vtime('tran "/VON") - vtime('tran "/VOP"))
  Output tstart = (VAR("t_stop") - (2 / VAR("frq")))
  Output tend = VAR("t_stop")
  Output (vtime('tran "/VOP") - vtime('tran "/VON"))
  Output "dft(vtime('tran \"/VOP\")-vtime('tran \"/VON\") 80*VAR(\"T\") 120*VAR(\"T\") 1023 \"BlackmanHarris\" 1 1 0.9 )" = dft((vtime('tran "/VOP") - vtime('tran "/VON")) (80 * VAR("T")) (120 * VAR("T")) 1023 "BlackmanHarris" 1 1 0.9)
  Output "vtime('tran \"/VOP\")-vtime('tran \"/VON\")" = (vtime('tran "/VOP") - vtime('tran "/VON"))
  Output dft_phase = dft(dB20((vtime('tran "/VOP") - vtime('tran "/VON"))) (80 * VAR("T")) (120 * VAR("T")) 1023 "BlackmanHarris" 1 (10**(1 / 20)) 0.9)
  Signals: /net15, /net16, /net7, /net5, /VOP, /VON
Run mode: Single Run, Sweeps and Corners
Corners:
  LSB (off): code_I=0:1:32; code_Q=32:-1:0
