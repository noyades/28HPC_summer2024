ADE simulation setup
Run mode: Single Run, Sweeps and Corners
Tests:
  dev28_behdad_tb_dev22_scpa_digital_PA_1: dev28_behdad/tb_dev22_scpa_digital_PA/schematic_stat_param, simulator spectre
    Variables: t_stop = 500*T; res = 2**N - 1; T = 1/frq; vdd = 0.9; N = 8; frq = 1.28G; L = 47p; R1 = 0.27; t_start = 0; code_I = 0; code_Q = 255; td = 0
    Outputs: tstart; tend
Corners:
  LSB (off): code_I=0:1:32; code_Q=32:-1:0
