ADE simulation setup
Run mode: Single Run, Sweeps and Corners
Tests:
  jswalling_tapeout_tb_inv_1: jswalling_tapeout/tb_inv/schematic, simulator spectre
    Variables: frf = 12.8G; vdd = 0.8; tStop = 48/frf
Corners (nominal off):
  C0: vdd=0.81 0.9 0.99
