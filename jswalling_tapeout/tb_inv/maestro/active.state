ADE simulation setup
Test jswalling_tapeout_tb_inv_1: jswalling_tapeout/tb_inv/schematic, simulator spectre
  Models: /projects/eddie_pritchard/RFIC/PDK/tsmc/28nm/v1.8_2p3a_10M/tsmcN28/../models/spectre/toplevel.scs[TOP_TT]
  Variables: frf = 12.8G; vdd = 0.8; tStop = 48/frf
  Temperature: 27
  Simulator options: additionalArgs=vdsatmod=gds
  Analysis tran: stop=VAR("tStop") errpreset=conservative
  Signals: /i, /o, /V0/MINUS (terminal)
Run mode: Single Run, Sweeps and Corners
Corners (nominal off):
  C0: vdd=0.81 0.9 0.99
