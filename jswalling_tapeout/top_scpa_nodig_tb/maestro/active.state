ADE simulation setup
Test jswalling_tapeout_top_scpa_nodig_tb_1: jswalling_tapeout/top_scpa_nodig_tb/config, simulator spectre
  Models: /data/PDK/tsmc/28nm/v1.8_2p3a_10M/tsmcN28/../models/spectre/toplevel.scs[TOP_TT]
  Variables: frq = 25.6G; vdd = 0.9; tstop = 120u; frf = frq/2
  Temperature: 27
  Simulator options: additionalArgs=vdsatmod=gds
  Files: vectors /data/projects/28HPC_summer2024/jswalling/synthesis/cadence/phase2_int_work/testbenches/80211be_pp_4_frf=12800000000.vec
  Analysis tran: stop=VAR("tstop")
  Signals: /RFCK, /RFOUT, /i4<7:0>, /i3<7:0>, /i2<7:0>, /i1<7:0>, /q4<7:0>, /q3<7:0>, /q2<7:0>, /q1<7:0>, /i4u<255:0>, /i3u<255:0>, /i2u<255:0>, /i1u<255:0>, /q4u<255:0>, /q3u<255:0>, /q2u<255:0>, /V3/MINUS (terminal), /VDDA
Run mode: Single Run, Sweeps and Corners
