ADE simulation setup
Run mode: Single Run, Sweeps and Corners
Tests:
  jswalling_tapeout_top_scpa_nodig_tb_1: jswalling_tapeout/top_scpa_nodig_tb/config, simulator spectre
    Variables: frq = 25.6G; vdd = 0.9; frf = frq/2; tstop = 120u
    Outputs: /i4<7:0>; /i3<7:0>; /i2<7:0>; /i1<7:0>; /q4<7:0>; /q3<7:0>; /q2<7:0>; /q1<7:0>; /i4u<255:0>; /i3u<255:0>; /i2u<255:0>; /i1u<255:0>; /q4u<255:0>; /q3u<255:0>; /q2u<255:0>
